// VAMS-2023 9.21, three schemes over the array data source.
//
//   lin   9.21.1's own sample set, f(x,y) = 0.5x + y on three ragged isolines,
//         with the default linear control in both dimensions.
//   cub   a cubic spline with constant extrapolation, so the end derivatives are
//         pinned to zero.
//   disc  closest point lookup, which never extrapolates.
`include "disciplines.vams"

module tabmod(lin, cub, disc, x, y);
    inout lin, cub, disc;
    electrical lin, cub, disc;
    input x, y;
    electrical x, y;

    analog begin
        V(lin) <+ $table_model(
            V(y), V(x),
            {0.0, 0.0, 0.0, 0.0, 0.0, 0.0, 0.5, 0.5, 0.5, 1.0, 1.0, 1.0},
            {1.0, 2.0, 3.0, 4.0, 5.0, 6.0, 1.0, 3.0, 5.0, 1.0, 2.0, 4.0},
            {0.5, 1.0, 1.5, 2.0, 2.5, 3.0, 1.0, 2.0, 3.0, 1.5, 2.0, 3.0});

        V(cub) <+ $table_model(V(x), {0.0, 1.0, 2.0, 3.0}, {0.0, 1.0, 4.0, 9.0}, "3CC");

        V(disc) <+ $table_model(V(x), {1.0, 3.0, 5.0}, {10.0, 30.0, 50.0}, "D");
    end
endmodule
