`include "disciplines.vams"

// VAMS-2023 5.10.3.1: `cross` should update `state` only when V(smpl) crosses the
// threshold upward, so `out` holds the value sampled at the last crossing.
//
// A voltage contribution puts its equation on the branch flow unknown, where it
// reads `state - V(out)`, so holding `V(out)` at zero makes that residual the
// sampled value itself.
(*openvaf_allow="unscheduled_event"*) module cross_detect(in, out, smpl);
    input in, smpl;
    output out;
    electrical in, out, smpl;

    parameter real thresh = 2.5;

    real state;

    analog begin
        @(cross(V(smpl) - thresh, +1))
            state = V(in);
        V(out) <+ state;
    end
endmodule
