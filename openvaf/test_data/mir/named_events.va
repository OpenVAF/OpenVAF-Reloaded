// VAMS-2023 5.10.4 (Mantis 7809): named events are declared with `event`,
// triggered with `-> name;` from an analog event statement and detected with
// `@(name)`.
// `@(timer(...))` is the only way to trigger a named event, and timer events are
// not scheduled yet, so allow the warning: this test is about the named-event
// lowering, not about the timer.
(*openvaf_allow="unscheduled_event"*) module named_events;
    parameter real thresh = 0.5;

    event sampled;
    event armed;

    integer early;
    integer hits;
    integer arm_count;

    analog begin
        early = 0;
        hits = 0;
        arm_count = 0;

        // detected before anything can trigger it: the guard is false, so the
        // body never runs
        @(sampled) early = 1;

        // triggered from an event statement, under a condition
        @(timer(1n)) begin
            if (thresh > 0.25)
                -> sampled;
        end

        // unconditional trigger
        @(timer(2n)) -> armed;

        // detected afterwards: runs iff the trigger executed
        @(sampled) hits = hits + 1;
        @(armed) arm_count = arm_count + 1;
    end
endmodule
