// VAMS-2023 §5.11 jump statements: break/continue in while, return in UDF.
module test;
    parameter integer n = 3;
    integer i;
    integer acc;
    real y;

    analog function real clamp_pos;
        input x;
        real x;
        begin
            if (x < 0.0) begin
                return 0.0;
            end
            return x;
        end
    endfunction

    analog begin
        i = 0;
        acc = 0;
        while (i < n) begin
            i = i + 1;
            if (i == 2) begin
                continue;
            end
            if (i > 10) begin
                break;
            end
            acc = acc + i;
        end
        y = clamp_pos(1.5);
    end
endmodule
