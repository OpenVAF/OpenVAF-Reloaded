* A measured curve and a filter, both carried by the model card: the same two
* compiled models, re-shaped per card.
*
* Each curve is in series with a 100 ohm sense resistor, so the waveform carries
* both the voltage across the device and the current through it. The ramp runs
* past both ends of the measurement grid, so the extrapolation is measured too.
.model rdef partcurve
.model rmeas partcurve is=[0 2e-4 2e-3 8e-3 2e-2]
* Two filters an octave and a half apart in corner, which is the only difference
* between them.
.model fdef cardfilt
.model fslow cardfilt num=[0.1] den=[1 -0.9]

vr rp 0 pwl(0 -0.25 100u 1.25)
Na rp rs1 rdef
Rs1 rs1 0 100
Nb rp rs2 rmeas
Rs2 rs2 0 100

vf fi 0 pwl(0 0 100u 1)
Nc fi fo1 fdef
Nd fi fo2 fslow
Rf1 fo1 0 1g
Rf2 fo2 0 1g

* A table is a kinked device: between two samples it is a straight line, and at a
* sample its slope changes. The last Newton iteration of a timepoint is accepted
* on a voltage tolerance, so with the default reltol the accepted solution can sit
* a few hundred microvolts across a knot from the voltage the device was last
* evaluated at, and the current in the file is then the neighbouring segment's.
* The curve is not wrong there; the solve is loose. A tight one leaves the file's
* own precision.
.options reltol=1e-8 vntol=1e-10 abstol=1e-16

.control
pre_osdi carddata.osdi
tran 200n 100u
set filetype=ascii
wrdata cd_out.txt v(rp) v(rs1) v(rs2) v(fi) v(fo1) v(fo2)
.endc

.end
