* A level detector with hysteresis over three cycles of a slow sine. The model
* writes fm_log.txt with four display tasks; wrdata writes the voltage the
* detector saw and the state it reported, which is what the analyzer checks the
* file against.
Nm in st mon
.model mon levelmon(vlo=0.4 vhi=0.6)
vin in 0 sin(0.5 0.5 1k)
Rs st 0 1e12

.control
pre_osdi fmonitor.osdi
tran 2u 3m
wrdata fm_out.txt v(in) v(st)
.endc

.end
