* timer(1u, 2u) sampling a ramp, VAMS-2023 5.10.3.3
* in   : a ramp from 0 V to 5 V over 10 us, so the value at each event names it
* out  : the held sample -- 0.5, 1.5, 2.5, 3.5, 4.5 V at 1, 3, 5, 7, 9 us
* tick : how many events have fired

Vin in 0 PWL(0 0 10u 5)

Nt in out tick tmod
.model tmod tsample()

Ro out  0 1e12
Rt tick 0 1e12

.control
pre_osdi timer.osdi
tran 20n 10u
wrdata tm_out.txt v(out) v(tick) v(in)
.endc

.end
